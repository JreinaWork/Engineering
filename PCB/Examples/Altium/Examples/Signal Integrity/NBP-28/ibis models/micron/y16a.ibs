| * y16a.ibs * IBIS 3.2 Model for MT48LC64M4A2, MT48LC32M8A2 & MT48LC16M16A2
|   TSOP Package (TG) and FBGA Package (FB)
[IBIS Ver]   3.2
[File name]   y16a.ibs
[File rev]   2.3
[Date]   05/02/2003
[Source]   From silicon level SPICE model at Micron Technology Inc.
   Micron Technology Inc.
   8000 S. Federal Way
   P.O. Box 6 M/S: 1-711
   Boise ID 83707-0006
[Notes]   Rev 1.0: 10/30/2001
   - initial file creation
   Rev 2.0 changes: 02/13/2002
   - dq model I-V curves matched to silicon measurements
   - input models matched to measurements
   - updated c_comp values for all models
   Rev 2.1 changes: 02/18/2002
   - FBGA package pinout error fixed
   Rev 2.2 changes: 06/04/2002
   - x16 FBGA package added
   Rev 2.3 changes: 05/02/2003
   - dq model I-V curves matched to silicon measurements
   - updated input capacitance of all models
[Disclaimer] THESE DESIGNS ARE PROVIDED "AS IS" WITH NO WARRANTY
                WHATSOEVER AND MICRON SPECIFICALLY DISCLAIMS ANY
                IMPLIED WARRANTIES OF MERCHANTABILITY FITNESS FOR
                A PARTICULAR PURPOSE OR AGAINST INFRINGEMENT.
[Copyright]   Copyright 2001 Micron Technology Inc. All Rights
   Reserved.
|   COMPONENT: MT48LC64M4A2TG SDRAM
[Component]   MT48LC64M4A2TG
[Manufacturer]   Micron Technology Inc.
[Package]   | TSOP Package
|variable   typ   min   max
R_pkg   38m   28m   49m
L_pkg   4.56nH   2.78nH   6.51nH
C_pkg   1.19pF   0.86pF   1.48pF
[Pin] signal_name   model_name   R_pin   L_pin   C_pin
1   VDD   POWER   30.4m   5.61nH   1.09pF
2   NC   NC
3   VDDQ   POWER   35.8m   5.12nH   1.23pF
4   NC   NC
5   DQ0   dqbuff   39.0m   4.16nH   1.20pF
6   VSSQ   GND   38.0m   4.18nH   1.15pF
7   NC   NC
8   NC   NC
9   VDDQ   POWER   32.4m   3.68nH   0.98pF
10   NC   NC
11   DQ1   dqbuff   29.6m   3.03nH   0.88pF
12   VSSQ   GND   28.0m   2.77nH   0.86pF
13   NC   NC
14   VDD   POWER   30.1m   3.42nH   0.92pF
15   NC   NC
16   WE   inbuff3   34.6m   4.67nH   1.05pF
17   CAS   inbuff   35.9m   4.32nH   1.08pF
18   RAS   inbuff   37.5m   4.30nH   1.12pF
19   CS   inbuff   39.6m   4.08nH   1.19pF
20   BA0   inbuff   41.7m   4.01nH   1.24pF
21   BA1   inbuff   43.6m   4.71nH   1.29pF
22   A10   inbuff   46.0m   4.93nH   1.35pF
23   A0   inbuff   47.9m   5.03nH   1.40pF
24   A1   inbuff   48.0m   5.42nH   1.37pF
25   A2   inbuff   45.5m   6.08nH   1.41pF
26   A3   inbuff   47.1m   6.51nH   1.48pF
27   VDD   POWER   28.2m   5.71nH   1.35pF
28   VSS   GND   28.1m   5.61nH   1.36pF
29   A4   inbuff   49.4m   5.86nH   1.47pF
30   A5   inbuff   48.4m   6.16nH   1.41pF
31   A6   inbuff   48.7m   5.55nH   1.38pF
32   A7   inbuff   47.1m   5.36nH   1.43pF
33   A8   inbuff   44.6m   4.65nH   1.37pF
34   A9   inbuff   41.7m   4.69nH   1.31pF
35   A11   inbuff   39.8m   4.40nH   1.23pF
36   A12   inbuff3   38.8m   4.14nH   1.20pF
37   CKE   inbuff4   37.7m   4.20nH   1.14pF
38   CLK   inbuff2   36.5m   3.79nH   1.08pF
39   DQM   inbuff   34.4m   3.79nH   1.02pF
40   NC   NC
41   VSS   GND   31.4m   3.15nH   0.93pF
42   NC   NC
43   VDDQ   POWER   27.5m   3.34nH   0.86pF
44   DQ2   dqbuff   29.1m   3.51nH   0.88pF
45   NC   NC
46   VSSQ   GND   33.6m   3.35nH   1.00pF
47   NC   NC
48   NC   NC
49   VDDQ   POWER   38.5m   4.04nH   1.16pF
50   DQ3   dqbuff   39.1m   4.29nH   1.20pF
51   NC   NC
52   VSSQ   GND   35.8m   5.09nH   1.22pF
53   NC   NC
54   VSS   GND   30.6m   5.62nH   1.07pF
|   COMPONENT: MT48LC32M8A2TG SDRAM
[Component]   MT48LC32M8A2TG
[Manufacturer]   Micron Technology Inc.
[Package]   | TSOP Package
|variable   typ   min   max
R_pkg   38m   28m   49m
L_pkg   4.55nH   2.78nH   6.51nH
C_pkg   1.19pF   0.86pF   1.48pF
[Pin] signal_name   model_name   R_pin   L_pin   C_pin
1   VDD   POWER   30.4m   5.61nH   1.09pF
2   DQ0   dqbuff   36.1m   4.95nH   1.35pF
3   VDDQ   POWER   35.8m   5.12nH   1.23pF
4   NC   NC
5   DQ1   dqbuff   39m   4.16nH   1.20pF
6   VSSQ   GND   38m   4.18nH   1.15pF
7   NC   NC
8   DQ2   dqbuff   33.5m   3.87nH   1.05pF
9   VDDQ   POWER   32.4m   3.68nH   0.98pF
10   NC   NC
11   DQ3   dqbuff   29.6m   3.03nH   0.88pF
12   VSSQ   GND   28m   2.77nH   0.86pF
13   NC   NC
14   VDD   POWER   30.1m   3.42nH   0.92pF
15   NC   NC
16   WE   inbuff3   34.6m   4.67nH   1.05pF
17   CAS   inbuff   35.9m   4.32nH   1.08pF
18   RAS   inbuff   37.5m   4.3nH   1.12pF
19   CS   inbuff   39.6m   4.08nH   1.19pF
20   BA0   inbuff   41.7m   4.01nH   1.24pF
21   BA1   inbuff   43.6m   4.71nH   1.29pF
22   A10   inbuff   46m   4.93nH   1.35pF
23   A0   inbuff   47.9m   5.03nH   1.40pF
24   A1   inbuff   48m   5.42nH   1.37pF
25   A2   inbuff   45.5m   6.08nH   1.41pF
26   A3   inbuff   47.1m   6.51nH   1.48pF
27   VDD   POWER   28.2m   5.71nH   1.35pF
28   VSS   GND   28.1m   5.61nH   1.36pF
29   A4   inbuff   49.4m   5.86nH   1.47pF
30   A5   inbuff   48.4m   6.16nH   1.41pF
31   A6   inbuff   48.7m   5.55nH   1.38pF
32   A7   inbuff   47.1m   5.36nH   1.43pF
33   A8   inbuff   44.6m   4.65nH   1.37pF
34   A9   inbuff   41.7m   4.69nH   1.31pF
35   A11   inbuff   39.8m   4.4nH   1.23pF
36   A12   inbuff3   38.8m   4.14nH   1.20pF
37   CKE   inbuff4   37.7m   4.2nH   1.14pF
38   CLK   inbuff2   36.5m   3.79nH   1.08pF
39   DQM   inbuff   34.4m   3.79nH   1.02pF
40   NC   NC
41   VSS   GND   31.4m   3.15nH   0.93pF
42   NC   NC
43   VDDQ   POWER   27.5m   3.34nH   0.86pF
44   DQ4   dqbuff   29.1m   3.51nH   0.88pF
45   NC   NC
46   VSSQ   GND   33.6m   3.35nH   1.00pF
47   DQ5   dqbuff   33.9m   3.76nH   1.05pF
48   NC   NC
49   VDDQ   POWER   38.5m   4.04nH   1.16pF
50   DQ6   dqbuff   39.1m   4.29nH   1.20pF
51   NC   NC
52   VSSQ   GND   35.8m   5.09nH   1.22pF
53   DQ7   dqbuff   36.1m   4.93nH   1.33pF
54   VSS   GND   30.6m   5.62nH   1.07pF
|   COMPONENT: MT48LC16M16A2TG SDRAM
[Component]   MT48LC16M16A2TG
[Manufacturer]   Micron Technology Inc.
[Package]   | TSOP Package
|variable   typ   min   max
R_pkg   37m   28m   49m
L_pkg   4.43nH   2.78nH   6.51nH
C_pkg   1.16pF   0.86pF   1.48pF
[Pin] signal_name   model_name   R_pin   L_pin   C_pin
1   VDD   POWER   30.4m   5.61nH   1.09pF
2   DQ0   dqbuff   36.1m   4.95nH   1.35pF
3   VDDQ   POWER   35.8m   5.12nH   1.23pF
4   DQ1   dqbuff   37.3m   4.74nH   1.17pF
5   DQ2   dqbuff   39m   4.16nH   1.20pF
6   VSSQ   GND   38m   4.18nH   1.15pF
7   DQ3   dqbuff   35.9m   3.92nH   1.11pF
8   DQ4   dqbuff   33.5m   3.87nH   1.05pF
9   VDDQ   POWER   32.4m   3.68nH   0.98pF
10   DQ5   dqbuff   31m   3.47nH   0.93pF
11   DQ6   dqbuff   29.6m   3.03nH   0.88pF
12   VSSQ   GND   28m   2.77nH   0.86pF
13   DQ7   dqbuff   29.4m   2.78nH   0.88pF
14   VDD   POWER   30.1m   3.42nH   0.92pF
15   DQML   inbuff   32.1m   4.05nH   0.98pF
16   WE   inbuff3   34.6m   4.67nH   1.05pF
17   CAS   inbuff   35.9m   4.32nH   1.08pF
18   RAS   inbuff   37.5m   4.3nH   1.12pF
19   CS   inbuff   39.6m   4.08nH   1.19pF
20   BA0   inbuff   41.7m   4.01nH   1.24pF
21   BA1   inbuff   43.6m   4.71nH   1.29pF
22   A10   inbuff   46m   4.93nH   1.35pF
23   A0   inbuff   47.9m   5.03nH   1.40pF
24   A1   inbuff   48m   5.42nH   1.37pF
25   A2   inbuff   45.5m   6.08nH   1.41pF
26   A3   inbuff   47.1m   6.51nH   1.48pF
27   VDD   POWER   28.2m   5.71nH   1.35pF
28   VSS   GND   28.1m   5.61nH   1.36pF
29   A4   inbuff   49.4m   5.86nH   1.47pF
30   A5   inbuff   48.4m   6.16nH   1.41pF
31   A6   inbuff   48.7m   5.55nH   1.38pF
32   A7   inbuff   47.1m   5.36nH   1.43pF
33   A8   inbuff   44.6m   4.65nH   1.37pF
34   A9   inbuff   41.7m   4.69nH   1.31pF
35   A11   inbuff   39.8m   4.4nH   1.23pF
36   A12   inbuff3   38.8m   4.14nH   1.20pF
37   CKE   inbuff4   37.7m   4.2nH   1.14pF
38   CLK   inbuff2   36.5m   3.79nH   1.08pF
39   DQMH   inbuff   34.4m   3.79nH   1.02pF
40   NC   NC
41   VSS   GND   31.4m   3.15nH   0.93pF
42   DQ8   dqbuff   28.8m   3.31nH   0.88pF
43   VDDQ   POWER   27.5m   3.34nH   0.86pF
44   DQ9   dqbuff   29.1m   3.51nH   0.88pF
45   DQ10   dqbuff   31.1m   3.59nH   0.94pF
46   VSSQ   GND   33.6m   3.35nH   1.00pF
47   DQ11   dqbuff   33.9m   3.76nH   1.05pF
48   DQ12   dqbuff   36.2m   3.8nH   1.11pF
49   VDDQ   POWER   38.5m   4.04nH   1.16pF
50   DQ13   dqbuff   39.1m   4.29nH   1.20pF
51   DQ14   dqbuff   37m   4.91nH   1.19pF
52   VSSQ   GND   35.8m   5.09nH   1.22pF
53   DQ15   dqbuff   36.1m   4.93nH   1.33pF
54   VSS   GND   30.6m   5.62nH   1.07pF
|   COMPONENT: MT48LC64M4A2FB SDRAM
[Component]   MT48LC64M4A2FB
[Manufacturer]   Micron Technology Inc.
[Package]   | FBGA Package
|variable   typ   min   max
R_pkg   62m   34m   81m
L_pkg   2.24nH   1.45nH   3.25nH
C_pkg   0.46pF   0.37pF   0.54pF
[Pin] signal_name   model_name   R_pin   L_pin   C_pin
A1   NC   NC
A2   VSS   GND   56.8m   1.94nH   0.44pF
A7   VDD   POWER   33.8m   1.44nH   0.45pF
A8   NC   NC
B1   NC   NC
B2   VSSQ   GND   56.5m   1.93nH   0.45pF
B7   VDDQ   POWER   57.6m   1.92nH   0.46pF
B8   NC   NC
C1   VDDQ   POWER   70.1m   2.63nH   0.46pF
C2   DQ3   dqbuff   56.8m   1.88nH   0.45pF
C7   DQ0   dqbuff   56.7m   1.87nH   0.44pF
C8   VSSQ   GND   68.7m   2.54nH   0.43pF
D1   NC   NC
D2   NC   NC
D7   NC   NC
D8   NC   NC
E1   NC   NC
E2   VSSQ   GND   56.7m   1.87nH   0.45pF
E7   VDDQ   POWER   54.0m   1.78nH   0.41pF
E8   NC   NC
F1   VDDQ   POWER   65.3m   2.45nH   0.42pF
F2   DQ2   dqbuff   54.5m   1.75nH   0.41pF
F7   DQ1   dqbuff   50.8m   1.63nH   0.42pF
F8   VSSQ   GND   64.5m   2.54nH   0.42pF
G1   NC   NC
G2   NC   NC
G7   NC   NC
G8   NC   NC
H1   NC   NC
H2   VSS   GND   53.8m   1.76nH   0.36pF
H7   VDD   POWER   52.2m   1.56nH   0.42pF
H8   NC   NC
J1   NC   NC
J2   DQM   inbuff   59.6m   1.93nH   0.39pF
J7   WE   inbuff3   50.9m   1.62nH   0.37pF
J8   CAS   inbuff   65.1m   2.61nH   0.38pF
K1   NC   NC
K2   CLK   inbuff2   58.0m   1.92nH   0.43pF
K7   RAS   inbuff   56.4m   1.86nH   0.46pF
K8   NC   NC
L1   A12   inbuff3   78.1m   2.84nH   0.52pF
L2   CKE   inbuff4   63.4m   2.19nH   0.49pF
L7   NC   NC
L8   CS   inbuff   68.3m   2.55nH   0.43pF
M1   A11   inbuff   76.8m   2.85nH   0.51pF
M2   A9   inbuff   62.3m   2.12nH   0.50pF
M7   BA1   inbuff   58.6m   2.00nH   0.48pF
M8   BA0   inbuff   69.9m   2.71nH   0.44pF
N1   A8   inbuff   76.3m   3.08nH   0.49pF
N2   A7   inbuff   64.1m   2.26nH   0.49pF
N7   A0   inbuff   62.4m   2.14nH   0.49pF
N8   A10   inbuff   73.3m   2.82nH   0.50pF
P1   A6   inbuff   77.6m   3.05nH   0.49pF
P2   A5   inbuff   65.0m   2.36nH   0.51pF
P7   A2   inbuff   66.0m   2.42nH   0.52pF
P8   A1   inbuff   77.9m   3.13nH   0.51pF
R1   A4   inbuff   80.6m   3.22nH   0.54pF
R2   VSS   GND   41.5m   1.54nH   0.52pF
R7   VDD   POWER   39.8m   1.52nH   0.49pF
R8   A3   inbuff   78.8m   3.24nH   0.51pF
|   COMPONENT: MT48LC32M8A2FB SDRAM
[Component]   MT48LC32M8A2FB
[Manufacturer]   Micron Technology Inc.
[Package]   | FBGA Package
|variable   typ   min   max
R_pkg   63m   34m   81m
L_pkg   2.28nH   1.45nH   3.25nH
C_pkg   0.46pF   0.37pF   0.54pF
[Pin] signal_name   model_name   R_pin   L_pin   C_pin
A1   DQ7   dqbuff   71.3m   2.74nH   0.45pF
A2   VSS   GND   56.8m   1.94nH   0.44pF
A7   VDD   POWER   33.8m   1.44nH   0.45pF
A8   DQ0   dqbuff   71.0m   2.69nH   0.46pF
B1   NC   NC
B2   VSSQ   GND   56.5m   1.93nH   0.45pF
B7   VDDQ   POWER   57.6m   1.92nH   0.46pF
B8   NC   NC
C1   VDDQ   POWER   70.1m   2.63nH   0.46pF
C2   DQ6   dqbuff   56.8m   1.88nH   0.45pF
C7   DQ1   dqbuff   56.7m   1.87nH   0.44pF
C8   VSSQ   GND   68.7m   2.54nH   0.43pF
D1   DQ5   dqbuff   69.0m   2.58nH   0.44pF
D2   NC   NC
D7   NC   NC
D8   DQ2   dqbuff   70.1m   2.64nH   0.43pF
E1   NC   NC
E2   VSSQ   GND   56.7m   1.87nH   0.45pF
E7   VDDQ   POWER   54.0m   1.78nH   0.41pF
E8   NC   NC
F1   VDDQ   POWER   65.3m   2.45nH   0.42pF
F2   DQ4   dqbuff   54.5m   1.75nH   0.41pF
F7   DQ3   dqbuff   50.8m   1.63nH   0.42pF
F8   VSSQ   GND   64.5m   2.54nH   0.42pF
G1   NC   NC
G2   NC   NC
G7   NC   NC
G8   NC   NC
H1   NC   NC
H2   VSS   GND   53.8m   1.76nH   0.36pF
H7   VDD   POWER   52.2m   1.56nH   0.42pF
H8   NC   NC
J1   NC   NC
J2   DQM   inbuff   59.6m   1.93nH   0.39pF
J7   WE   inbuff3   50.9m   1.62nH   0.37pF
J8   CAS   inbuff   65.1m   2.61nH   0.38pF
K1   NC   NC
K2   CLK   inbuff2   58.0m   1.92nH   0.43pF
K7   RAS   inbuff   56.4m   1.86nH   0.46pF
K8   NC   NC
L1   A12   inbuff3   78.1m   2.84nH   0.52pF
L2   CKE   inbuff4   63.4m   2.19nH   0.49pF
L7   NC   NC
L8   CS   inbuff   68.3m   2.55nH   0.43pF
M1   A11   inbuff   76.8m   2.85nH   0.51pF
M2   A9   inbuff   62.3m   2.12nH   0.50pF
M7   BA1   inbuff   58.6m   2.00nH   0.48pF
M8   BA0   inbuff   69.9m   2.71nH   0.44pF
N1   A8   inbuff   76.3m   3.08nH   0.49pF
N2   A7   inbuff   64.1m   2.26nH   0.49pF
N7   A0   inbuff   62.4m   2.14nH   0.49pF
N8   A10   inbuff   73.3m   2.82nH   0.50pF
P1   A6   inbuff   77.6m   3.05nH   0.49pF
P2   A5   inbuff   65.0m   2.36nH   0.51pF
P7   A2   inbuff   66.0m   2.42nH   0.52pF
P8   A1   inbuff   77.9m   3.13nH   0.51pF
R1   A4   inbuff   80.6m   3.22nH   0.54pF
R2   VSS   GND   41.5m   1.54nH   0.52pF
R7   VDD   POWER   39.8m   1.52nH   0.49pF
R8   A3   inbuff   78.8m   3.24nH   0.51pF
|   COMPONENT: MT48LC16M16A2FG SDRAM
[Component]   MT48LC16M16A2FG
[Manufacturer]   Micron Technology Inc.
[Package]   | FBGA Package
|variable   typ   min   max
R_pkg   61m   44m   83m
L_pkg   2.11nH   1.22nH   3.25nH
C_pkg   0.24pf   0.16pf   0.33pf
[Pin] signal_name   model_name   R_pin   L_pin   C_pin
A1   VSS   GND   66m   3.30nH   0.31pf
A2   DQ15   dqbuff   76m   2.34nH   0.29pf
A3   VSSQ   GND   64m   2.01nH   0.22pf
A7   VDDQ   POWER   51m   1.60nH   0.21pf
A8   DQ0   dqbuff   75m   2.49nH   0.27pf
A9   VDD   POWER   69m   3.53nH   0.29pf
B1   DQ14   dqbuff   81m   3.11nH   0.31pf
B2   DQ13   dqbuff   70m   2.36nH   0.29pf
B3   VDDQ   POWER   48m   1.46nH   0.18pf
B7   VSSQ   GND   50m   1.60nH   0.21pf
B8   DQ2   dqbuff   72m   2.49nH   0.31pf
B9   DQ1   dqbuff   83m   3.25nH   0.33pf
C1   DQ12   dqbuff   74m   2.90nH   0.27pf
C2   DQ11   dqbuff   60m   2.05nH   0.24pf
C3   VSSQ   GND   45m   1.29nH   0.17pf
C7   VDDQ   POWER   45m   1.34nH   0.18pf
C8   DQ4   dqbuff   60m   2.11nH   0.25pf
C9   DQ3   dqbuff   76m   3.04nH   0.28pf
D1   DQ10   dqbuff   74m   2.89nH   0.27pf
D2   DQ9   dqbuff   58m   1.98nH   0.24pf
D3   VDDQ   POWER   44m   1.22nH   0.17pf
D7   VSSQ   GND   44m   1.29nH   0.18pf
D8   DQ6   dqbuff   59m   2.07nH   0.24pf
D9   DQ5   dqbuff   72m   2.89nH   0.27pf
E1   DQ8   dqbuff   71m   2.63nH   0.25pf
E2   NC   NC
E3   VSS   GND   46m   1.38nH   0.19pf
E7   VDD   POWER   47m   1.49nH   0.19pf
E8   LDQM   inbuff   61m   1.94nH   0.24pf
E9   DQ7   dqbuff   72m   2.70nH   0.25pf
F1   UDQM   inbuff   78m   2.78nH   0.30pf
F2   CLK   inbuff2   62m   2.01nH   0.25pf
F3   CKE   inbuff4   44m   1.27nH   0.18pf
F7   CAS   inbuff   46m   1.38nH   0.18pf
F8   RAS   inbuff   61m   2.10nH   0.25pf
F9   WE   inbuff3   72m   2.79nH   0.26pf
G1   A12   inbuff3   71m   2.83nH   0.26pf
G2   A11   inbuff   60m   2.05nH   0.24pf
G3   A9   inbuff   46m   1.30nH   0.18pf
G7   BA0   inbuff   45m   1.36nH   0.18pf
G8   BA1   inbuff   62m   2.15nH   0.24pf
G9   CS   inbuff   73m   2.90nH   0.27pf
H1   A8   inbuff   74m   2.92nH   0.27pf
H2   A7   inbuff   60m   2.04nH   0.24pf
H3   A6   inbuff   44m   1.26nH   0.18pf
H7   A0   inbuff   47m   1.38nH   0.19pf
H8   A1   inbuff   61m   2.09nH   0.25pf
H9   A10   inbuff   71m   2.84nH   0.27pf
J1   VSS   GND   63m   3.01nH   0.28pf
J2   A5   inbuff   68m   2.26nH   0.25pf
J3   A4   inbuff   45m   1.32nH   0.17pf
J7   A3   inbuff   44m   1.29nH   0.16pf
J8   A2   inbuff   57m   2.01nH   0.23pf
J9   VDD   POWER   58m   2.85nH   0.28pf
| Models and submodels in the file (5): dqbuff (I/O), inbuff (Input), inbuff2 (Input), inbuff3 (Input), inbuff4 (Input)
